// VerilogA for memristor_multipliers, DAC, veriloga

`include "constants.vams"
`include "disciplines.vams"

module DAC_16(vin,vout);

parameter real mid = 0.8;

input[0:16-1] vin;
output vout;
electrical[0:16-1] vin;
electrical vout;
real res;
genvar i;

analog begin
	res = 0;
	for(i=0;i<16;i=i+1)begin
		res = res + (V(vin[i])>mid)*pow(2,i);
	end
	V(vout) <+ transition(res);
end

endmodule
